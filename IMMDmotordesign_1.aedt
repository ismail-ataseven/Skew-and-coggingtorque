# Ansys Electronics Desktop project, version 2017.0
project variables:
  $cond = 40
  $ind = 1.30732e-005H
  $res = 0.277107ohm
  $vpeak = 120V
  $ang = -7deg
materials:
  M19-24G: permeability{BType=normal HUnit=A_per_meter BUnit=tesla curve (0, 0) (22.28, 0.05) (25.46, 0.1) (31.83, 0.15) (47.74, 0.36) (63.66, 0.54) (79.57, 0.65) (159.15, 0.99) (318.3, 1.2) (477.46, 1.28) (636.61, 1.33) (795.77, 1.36) (1591.5, 1.44) (3183, 1.52) (4774.6, 1.58) (6366.1, 1.63) (7957.7, 1.67) (15915, 1.8) (31830, 1.9) (111407, 2) (190984, 2.1) (350138, 2.3) (509292, 2.5)} core_loss_type="Electrical Steel" core_loss_kc=4.3255556 mass_density=7650
  XG196/96: permeability{BType=normal HUnit=A_per_meter BUnit=tesla curve (-690000, 0) (-663113.52, 0.048797862) (-635337.77, 0.097595724) (-606627.88, 0.14639359) (-576935.93, 0.19519145) (-546210.65, 0.24398931) (-514397.15, 0.29278717) (-481436.56, 0.34158503) (-447265.71, 0.39038289) (-411816.7, 0.43918076) (-375016.43, 0.48797862) (-333347.94, 0.54110533) (-291679.45, 0.5934675) (-250010.95, 0.64582967) (-208342.46, 0.69819184) (-166673.97, 0.75055402) (-125005.48, 0.80291619) (-83336.985, 0.85527836) (-41668.492, 0.90764053) (0, 0.96)}
  vacuum: permittivity=1
  M19-24G_2DSF0.950: permeability{BType=normal HUnit=A_per_meter BUnit=tesla curve (0, 0) (22.28, 0.0475014) (25.46, 0.0950016) (31.83, 0.142502) (47.74, 0.342003) (63.66, 0.513004) (79.57, 0.617505) (159.15, 0.94051) (318.3, 1.14002) (477.46, 1.21603) (636.61, 1.26354) (795.77, 1.29205) (1591.5, 1.3681) (3183, 1.4442) (4774.6, 1.5013) (6366.1, 1.5489) (7957.7, 1.587) (15915, 1.711) (31830, 1.807) (111407, 1.907) (190984, 2.007) (350138, 2.207) (509292, 2.407) (2100830, 4.407)} core_loss_type="Electrical Steel" core_loss_kc=4.55322 mass_density=7650
  XG196/96_2DSF1.000_N: CoordinateSystemType=Cylindrical permeability=1 magnetic_coercivity{Magnitude=-726962A_per_meter DirComp1=1 DirComp2=0 DirComp3=0}
  XG196/96_2DSF1.000_S: CoordinateSystemType=Cylindrical permeability=1 magnetic_coercivity{Magnitude=-726962A_per_meter DirComp1=-1 DirComp2=0 DirComp3=0}
  copper: permeability=0.999991 conductivity=58000000
  NdFe35: permittivity=1 permeability=1.0997785 conductivity=625000 magnetic_coercivity{Magnitude=-890000A_per_meter DirComp1=1 DirComp2=0 DirComp3=0} lande_g_factor=2
  NdFe35_2DSF1.000_N: CoordinateSystemType=Cylindrical permeability=1.09978 magnetic_coercivity{Magnitude=-890000A_per_meter DirComp1=1 DirComp2=0 DirComp3=0}
  NdFe35_2DSF1.000_S: CoordinateSystemType=Cylindrical permeability=1.09978 magnetic_coercivity{Magnitude=-890000A_per_meter DirComp1=-1 DirComp2=0 DirComp3=0}
  NdFe45: CoordinateSystemType=Cylindrical permeability=1.09978 magnetic_coercivity{Magnitude=-976827.97A_per_meter DirComp1=1 DirComp2=0 DirComp3=0}
  NdFe45_S: CoordinateSystemType=Cylindrical permeability=1.09978 magnetic_coercivity{Magnitude=-976827.97A_per_meter DirComp1=-1 DirComp2=0 DirComp3=0}
  m250-35a: permeability{BType=normal HUnit=A_per_meter BUnit=tesla curve (0, 0) (26.8, 0.1) (35.7, 0.2) (41.8, 0.3) (47.5, 0.4) (53.4, 0.5) (60, 0.6) (67.9, 0.7) (77.5, 0.8) (90, 0.9) (107, 1) (133, 1.1) (179, 1.2) (284, 1.3) (642, 1.4) (1810, 1.5) (4030, 1.6) (7290, 1.7) (11700, 1.8)} core_loss_type="Electrical Steel" core_loss_kc=4.55322 mass_density=7650
  NdFe45_2DSF1.000_N: CoordinateSystemType=Cylindrical permeability=1.09978 magnetic_coercivity{Magnitude=-976828A_per_meter DirComp1=1 DirComp2=0 DirComp3=0}
  NdFe45_2DSF1.000_S: CoordinateSystemType=Cylindrical permeability=1.09978 magnetic_coercivity{Magnitude=-976828A_per_meter DirComp1=-1 DirComp2=0 DirComp3=0}

design 270mm150gap_FinalDesign (Maxwell 2D, Transient, XY geometry, model units mm)
options: ModelDepth=135mm SkewAngle=4.5deg NumberOfSlices=3 PlotFieldOnSlice=1 Multiplier=fractions
variables:
  fractions = 1
  embrace = 0.782
  offset = 53mm
geometry:
  Tool = user_primitive(RMxprt/Band, DiaGap=178.5mm, DiaYoke=270mm, Length=0mm, SegAngle=1.1538462deg, Fractions=fractions, HalfAxial=0, InfoCore=1)
  Coil_0 = user_primitive(RMxprt/LapCoil, DiaGap=180mm, DiaYoke=270mm, Length=0mm, Skew=0deg, Slots=24, SlotType=3, Hs0=2mm, Hs1=1mm, Hs2=30mm, Bs0=10.9mm, Bs1=11.331699mm, Bs2=19.230849mm, Rs=1mm, FilletType=0, Layers=2, CoilPitch=1, EndExt=0mm, SpanExt=0mm, BendAngle=0deg, SegAngle=5deg, LenRegion=0mm, InfoCoil=2)
  Coil_1..Coil_23 = Coil_0.duplicate_around_axis(axis=Z, angle=15deg, total=24)
  Coil_0.unite(Coil_6, Coil_12, Coil_18)
  Coil_1.unite(Coil_7, Coil_13, Coil_19)
  Coil_2.unite(Coil_8, Coil_14, Coil_20)
  Coil_3.unite(Coil_9, Coil_15, Coil_21)
  Coil_4.unite(Coil_10, Coil_16, Coil_22)
  Coil_5.unite(Coil_11, Coil_17, Coil_23)
  CoilRe_0 = user_primitive(RMxprt/LapCoil, DiaGap=180mm, DiaYoke=270mm, Length=0mm, Skew=0deg, Slots=24, SlotType=3, Hs0=2mm, Hs1=1mm, Hs2=30mm, Bs0=10.9mm, Bs1=11.331699mm, Bs2=19.230849mm, Rs=1mm, FilletType=0, Layers=2, CoilPitch=1, EndExt=0mm, SpanExt=0mm, BendAngle=0deg, SegAngle=5deg, LenRegion=0mm, InfoCoil=3)
  CoilRe_0.rotate(axis=Z, angle=-15deg)
  CoilRe_1..CoilRe_23 = CoilRe_0.duplicate_around_axis(axis=Z, angle=15deg, total=24)
  CoilRe_0.unite(CoilRe_6, CoilRe_12, CoilRe_18)
  CoilRe_1.unite(CoilRe_7, CoilRe_13, CoilRe_19)
  CoilRe_2.unite(CoilRe_8, CoilRe_14, CoilRe_20)
  CoilRe_3.unite(CoilRe_9, CoilRe_15, CoilRe_21)
  CoilRe_4.unite(CoilRe_10, CoilRe_16, CoilRe_22)
  CoilRe_5.unite(CoilRe_11, CoilRe_17, CoilRe_23)
  Mag_0 = user_primitive(RMxprt/PMCore, DiaGap=177mm, DiaYoke=120mm, Length=0mm, Poles=20, PoleType=1, Embrace=embrace, ThickMag=7mm, WidthMag=0mm, Offset=offset, Bridge=0mm, Rib=0mm, LenRegion=0mm, InfoCore=2)
  Mag_1 = Mag_0.duplicate_around_axis(axis=Z, angle=18deg, total=20)  # copies kept: 1
  Tool_5 = Tool.copy()
  Coil_0.subtract(Tool_5)
  Tool_6 = Tool.copy()
  Coil_1.subtract(Tool_6)
  Tool_7 = Tool.copy()
  Coil_2.subtract(Tool_7)
  Tool_8 = Tool.copy()
  Coil_3.subtract(Tool_8)
  Tool_9 = Tool.copy()
  Coil_4.subtract(Tool_9)
  Tool_10 = Tool.copy()
  Coil_5.subtract(Tool_10)
  Tool_11 = Tool.copy()
  CoilRe_0.subtract(Tool_11)
  Tool_12 = Tool.copy()
  CoilRe_1.subtract(Tool_12)
  Tool_13 = Tool.copy()
  CoilRe_2.subtract(Tool_13)
  Tool_14 = Tool.copy()
  CoilRe_3.subtract(Tool_14)
  Tool_15 = Tool.copy()
  CoilRe_4.subtract(Tool_15)
  Tool_16 = Tool.copy()
  CoilRe_5.subtract(Tool_16)
  Tool_18 = Tool.copy()
  Mag_0.subtract(Tool_18)
  Tool_19 = Tool.copy()
  Mag_1.subtract(Tool_19)
  Tool.delete()
  M1PhAC2pos [copper] = Coil_0.split(plane=YZ, keep=Both)
  Coil_0.delete()
  M1PhBC1pos [copper] = Coil_1.split(plane=YZ, keep=Both)
  Coil_1.delete()
  M1PhBC2neg [copper] = Coil_2.split(plane=YZ, keep=Both)
  Coil_2.delete()
  M1PhCC1neg [copper] = Coil_3.split(plane=YZ, keep=Both)
  Coil_3.delete()
  M1PhCC2pos [copper] = Coil_4.split(plane=YZ, keep=Both)
  Coil_4.delete()
  M2PhAC1pos [copper] = Coil_5.split(plane=YZ, keep=Both)
  Coil_5.delete()
  M1PhAC1pos [copper] = CoilRe_0.split(plane=YZ, keep=Both)
  CoilRe_0.delete()
  M1PhAC2neg [copper] = CoilRe_1.split(plane=YZ, keep=Both)
  CoilRe_1.delete()
  M1PhBC1neg [copper] = CoilRe_2.split(plane=YZ, keep=Both)
  CoilRe_2.delete()
  M1PhBC2pos [copper] = CoilRe_3.split(plane=YZ, keep=Both)
  CoilRe_3.delete()
  M1PhCC1pos [copper] = CoilRe_4.split(plane=YZ, keep=Both)
  CoilRe_4.delete()
  M1PhCC2neg [copper] = CoilRe_5.split(plane=YZ, keep=Both)
  CoilRe_5.delete()
  Split1 [NdFe45_2DSF1.000_N] = Mag_0.split(plane=YZ, keep=Both)
  Mag_0.delete()
  Split2 [NdFe45_2DSF1.000_S] = Mag_1.split(plane=YZ, keep=Both)
  Mag_1.delete()
  [M1PhAC2pos, M1PhBC1pos, M1PhBC2neg, M1PhCC1neg, M1PhCC2pos, M2PhAC1pos, M1PhAC1pos, M1PhAC2neg, M1PhBC1neg, M1PhBC2pos, M1PhCC1pos, M1PhCC2neg, Split1, Split2].split(plane=ZX, keep=PositiveOnly)
  Split1.duplicate_around_axis(axis=Z, angle=36deg, total=10, attached)
  Split2.duplicate_around_axis(axis=Z, angle=36deg, total=10, attached)
  M2PhCC1pos, M3PhCC1neg, M4PhCC1pos [copper] = M1PhCC1neg.duplicate_around_axis(axis=Z, angle=90deg, total=4)
  M2PhAC2neg, M3PhAC2pos, M4PhAC2neg [copper] = M1PhAC2pos.duplicate_around_axis(axis=Z, angle=90deg, total=4)
  M2PhBC1neg, M3PhBC1pos, M4PhBC1neg [copper] = M1PhBC1pos.duplicate_around_axis(axis=Z, angle=90deg, total=4)
  M2PhBC2pos, M3PhBC2neg, M4PhBC2pos [copper] = M1PhBC2neg.duplicate_around_axis(axis=Z, angle=90deg, total=4)
  M2PhCC2neg, M3PhCC2pos, M4PhCC2neg [copper] = M1PhCC2pos.duplicate_around_axis(axis=Z, angle=90deg, total=4)
  M3PhAC1neg, M4PhAC1pos, M1PhAC1neg [copper] = M2PhAC1pos.duplicate_around_axis(axis=Z, angle=90deg, total=4)
  M2PhAC1neg, M3PhAC1pos, M4PhAC1neg [copper] = M1PhAC1pos.duplicate_around_axis(axis=Z, angle=90deg, total=4)
  M2PhAC2pos, M3PhAC2neg, M4PhAC2pos [copper] = M1PhAC2neg.duplicate_around_axis(axis=Z, angle=90deg, total=4)
  M2PhBC1pos, M3PhBC1neg, M4PhBC1pos [copper] = M1PhBC1neg.duplicate_around_axis(axis=Z, angle=90deg, total=4)
  M2PhBC2neg, M3PhBC2pos, M4PhBC2neg [copper] = M1PhBC2pos.duplicate_around_axis(axis=Z, angle=90deg, total=4)
  M2PhCC1neg, M3PhCC1pos, M4PhCC1neg [copper] = M1PhCC1pos.duplicate_around_axis(axis=Z, angle=90deg, total=4)
  M2PhCC2pos, M3PhCC2neg, M4PhCC2pos [copper] = M1PhCC2neg.duplicate_around_axis(axis=Z, angle=90deg, total=4)
  Stator [M19-24G_2DSF0.950] = user_primitive(RMxprt/SlotCore, DiaGap=180mm, DiaYoke=270mm, Length=0mm, Skew=0deg, Slots=24, SlotType=3, Hs0=2mm, Hs01=0mm, Hs1=1mm, Hs2=30mm, Bs0=10.9mm, Bs1=11.331699mm, Bs2=19.230849mm, Rs=1mm, FilletType=0, HalfSlot=0, SegAngle=15deg, LenRegion=0mm, InfoCore=0)
  Tool1 = user_primitive(RMxprt/Band, DiaGap=178.5mm, DiaYoke=270mm, Length=0mm, SegAngle=1.1538462deg, Fractions=fractions, HalfAxial=0, InfoCore=1)
  Tool_4 = Tool1.copy()
  Stator.subtract(Tool_4)
  Tool1.delete()
  Shaft [vacuum] = user_primitive(RMxprt/Band, DiaGap=178.5mm, DiaYoke=120mm, Length=0mm, SegAngle=1.1538462deg, Fractions=1, HalfAxial=0, InfoCore=100)
  Tool2 = user_primitive(RMxprt/Band, DiaGap=178.5mm, DiaYoke=270mm, Length=0mm, SegAngle=1.1538462deg, Fractions=fractions, HalfAxial=0, InfoCore=1)
  Tool_3 = Tool2.copy()
  Shaft.subtract(Tool_3)
  Rotor [M19-24G_2DSF0.950] = user_primitive(RMxprt/PMCore, DiaGap=177mm, DiaYoke=120mm, Length=0mm, Poles=20, PoleType=1, Embrace=0.81, ThickMag=6mm, WidthMag=0mm, Offset=50mm, Bridge=0mm, Rib=0mm, LenRegion=0mm, InfoCore=0)
  Tool_17 = Tool2.copy()
  Rotor.subtract(Tool_17)
  Rotor.separate_bodies()
  Mag_01 = user_primitive(RMxprt/PMCore, DiaGap=177mm, DiaYoke=120mm, Length=0mm, Poles=20, PoleType=1, Embrace=embrace, ThickMag=7mm, WidthMag=0mm, Offset=offset, Bridge=0mm, Rib=0mm, LenRegion=0mm, InfoCore=2)
  Mag_20, Mag_2..Mag_19 = Mag_01.duplicate_around_axis(axis=Z, angle=18deg, total=20)
  Mag_01.unite(Mag_5, Mag_10, Mag_15)
  Tool_22 = Tool2.copy()
  Mag_01.subtract(Tool_22)
  Mag_0_1 = Mag_01.copy()
  Mag_20.unite(Mag_6, Mag_11, Mag_16)
  Tool_23 = Tool2.copy()
  Mag_20.subtract(Tool_23)
  Mag_1_1 = Mag_20.copy()
  Mag_2.unite(Mag_7, Mag_12, Mag_17)
  Tool_20 = Tool2.copy()
  Mag_2.subtract(Tool_20)
  Mag_2_1 = Mag_2.copy()
  Mag_3.unite(Mag_8, Mag_13, Mag_18)
  Tool_21 = Tool2.copy()
  Mag_3.subtract(Tool_21)
  Mag_3_1 = Mag_3.copy()
  Mag_4.unite(Mag_9, Mag_14, Mag_19)
  Mag_4.subtract(Tool2)
  Mag_4_1 = Mag_4.copy()
  Rotor.subtract(Mag_0_1, Mag_1_1, Mag_2_1, Mag_3_1, Mag_4_1)
  [Mag_01, Mag_20, Mag_2, Mag_3, Mag_4].delete()
  OuterRegion [vacuum] = user_primitive(RMxprt/Band, DiaGap=178.5mm, DiaYoke=270mm, Length=0mm, SegAngle=1.1538462deg, Fractions=fractions, HalfAxial=0, InfoCore=100)
  Band [vacuum] = user_primitive(RMxprt/Band, DiaGap=178.5mm, DiaYoke=120mm, Length=0mm, SegAngle=1.1538462deg, Fractions=1, HalfAxial=0, InfoCore=0)
  Tool3 = user_primitive(RMxprt/Band, DiaGap=178.5mm, DiaYoke=270mm, Length=0mm, SegAngle=1.1538462deg, Fractions=fractions, HalfAxial=0, InfoCore=1)
  Tool_1 = Tool3.copy()
  Band.subtract(Tool_1)
  InnerRegion [vacuum] = user_primitive(RMxprt/PMCore, DiaGap=177mm, DiaYoke=120mm, Length=0mm, Poles=20, PoleType=1, Embrace=0.81, ThickMag=6mm, WidthMag=0mm, Offset=53mm, Bridge=0mm, Rib=0mm, LenRegion=0mm, InfoCore=100)
  Tool_2 = Tool3.copy()
  InnerRegion.subtract(Tool_2)
  Tool3.delete()
  [Split1, Split2, Rotor, InnerRegion].rotate(axis=Z, angle=-10.95deg)
  [InnerRegion, Split2, Split1, Rotor].rotate(axis=Z, angle=90deg)
  [InnerRegion, Band, Split2, Split1, Rotor].rotate(axis=Z, angle=25deg)
  [InnerRegion, Band, Split2, Split1, Rotor].rotate(axis=Z, angle=-23.5deg)
motion:
  MotionSetup1: Band Move_Type=Rotate Coordinate_System=Global Axis=Z Is_Positive=true InitPos=0deg Angular_Velocity=600rpm Objects=Band
  Moving1: Moving Objects=[Split1, Split2, Shaft, Rotor, InnerRegion]
boundaries and excitations:
  VectorPotential1: Vector Potential Edges=OuterRegion.edge(at (0, 135, 0)) Value=0
  M1PhAC1neg: Coil Objects=M1PhAC1neg Conductor_number=$cond Winding=M1PhA PolarityType=Negative
  M1PhAC1pos: Coil Objects=M1PhAC1pos Conductor_number=$cond Winding=M1PhA PolarityType=Positive
  M1PhAC2neg: Coil Objects=M1PhAC2neg Conductor_number=$cond Winding=M1PhA PolarityType=Negative
  M1PhAC2pos: Coil Objects=M1PhAC2pos Conductor_number=$cond Winding=M1PhA PolarityType=Positive
  M1PhBC1neg: Coil Objects=M1PhBC1neg Conductor_number=$cond Winding=M1PhB PolarityType=Negative
  M1PhBC1pos: Coil Objects=M1PhBC1pos Conductor_number=$cond Winding=M1PhB PolarityType=Positive
  M1PhBC2neg: Coil Objects=M1PhBC2neg Conductor_number=$cond Winding=M1PhB PolarityType=Negative
  M1PhBC2pos: Coil Objects=M1PhBC2pos Conductor_number=$cond Winding=M1PhB PolarityType=Positive
  M1PhCC1neg: Coil Objects=M1PhCC1neg Conductor_number=$cond Winding=M1PhC PolarityType=Negative
  M1PhCC1pos: Coil Objects=M1PhCC1pos Conductor_number=$cond Winding=M1PhC PolarityType=Positive
  M1PhCC2neg: Coil Objects=M1PhCC2neg Conductor_number=$cond Winding=M1PhC PolarityType=Negative
  M1PhCC2pos: Coil Objects=M1PhCC2pos Conductor_number=$cond Winding=M1PhC PolarityType=Positive
  M2PhAC1neg: Coil Objects=M2PhAC1neg Conductor_number=$cond Winding=M2PhA PolarityType=Negative
  M2PhAC1pos: Coil Objects=M2PhAC1pos Conductor_number=$cond Winding=M2PhA PolarityType=Positive
  M2PhAC2neg: Coil Objects=M2PhAC2neg Conductor_number=$cond Winding=M2PhA PolarityType=Negative
  M2PhAC2pos: Coil Objects=M2PhAC2pos Conductor_number=$cond Winding=M2PhA PolarityType=Positive
  M2PhBC1neg: Coil Objects=M2PhBC1neg Conductor_number=$cond Winding=M2PhB PolarityType=Negative
  M2PhBC1pos: Coil Objects=M2PhBC1pos Conductor_number=$cond Winding=M2PhB PolarityType=Positive
  M2PhBC2neg: Coil Objects=M2PhBC2neg Conductor_number=$cond Winding=M2PhB PolarityType=Negative
  M2PhBC2pos: Coil Objects=M2PhBC2pos Conductor_number=$cond Winding=M2PhB PolarityType=Positive
  M2PhCC1neg: Coil Objects=M2PhCC1neg Conductor_number=$cond Winding=M2PhC PolarityType=Negative
  M2PhCC1pos: Coil Objects=M2PhCC1pos Conductor_number=$cond Winding=M2PhC PolarityType=Positive
  M2PhCC2neg: Coil Objects=M2PhCC2neg Conductor_number=$cond Winding=M2PhC PolarityType=Negative
  M2PhCC2pos: Coil Objects=M2PhCC2pos Conductor_number=$cond Winding=M2PhC PolarityType=Positive
  M3PhAC1neg: Coil Objects=M3PhAC1neg Conductor_number=$cond Winding=M3PhA PolarityType=Negative
  M3PhAC1pos: Coil Objects=M3PhAC1pos Conductor_number=$cond Winding=M3PhA PolarityType=Positive
  M3PhAC2neg: Coil Objects=M3PhAC2neg Conductor_number=$cond Winding=M3PhA PolarityType=Negative
  M3PhAC2pos: Coil Objects=M3PhAC2pos Conductor_number=$cond Winding=M3PhA PolarityType=Positive
  M3PhBC1neg: Coil Objects=M3PhBC1neg Conductor_number=$cond Winding=M3PhB PolarityType=Negative
  M3PhBC1pos: Coil Objects=M3PhBC1pos Conductor_number=$cond Winding=M3PhB PolarityType=Positive
  M3PhBC2neg: Coil Objects=M3PhBC2neg Conductor_number=$cond Winding=M3PhB PolarityType=Negative
  M3PhBC2pos: Coil Objects=M3PhBC2pos Conductor_number=$cond Winding=M3PhB PolarityType=Positive
  M3PhCC1neg: Coil Objects=M3PhCC1neg Conductor_number=$cond Winding=M3PhC PolarityType=Negative
  M3PhCC1pos: Coil Objects=M3PhCC1pos Conductor_number=$cond Winding=M3PhC PolarityType=Positive
  M3PhCC2neg: Coil Objects=M3PhCC2neg Conductor_number=$cond Winding=M3PhC PolarityType=Negative
  M3PhCC2pos: Coil Objects=M3PhCC2pos Conductor_number=$cond Winding=M3PhC PolarityType=Positive
  M4PhAC1neg: Coil Objects=M4PhAC1neg Conductor_number=$cond Winding=M4PhA PolarityType=Negative
  M4PhAC1pos: Coil Objects=M4PhAC1pos Conductor_number=$cond Winding=M4PhA PolarityType=Positive
  M4PhAC2neg: Coil Objects=M4PhAC2neg Conductor_number=$cond Winding=M4PhA PolarityType=Negative
  M4PhAC2pos: Coil Objects=M4PhAC2pos Conductor_number=$cond Winding=M4PhA PolarityType=Positive
  M4PhBC1neg: Coil Objects=M4PhBC1neg Conductor_number=$cond Winding=M4PhB PolarityType=Negative
  M4PhBC1pos: Coil Objects=M4PhBC1pos Conductor_number=$cond Winding=M4PhB PolarityType=Positive
  M4PhBC2neg: Coil Objects=M4PhBC2neg Conductor_number=$cond Winding=M4PhB PolarityType=Negative
  M4PhBC2pos: Coil Objects=M4PhBC2pos Conductor_number=$cond Winding=M4PhB PolarityType=Positive
  M4PhCC1pos: Coil Objects=M4PhCC1pos Conductor_number=$cond Winding=M4PhC PolarityType=Positive
  M4PhCC1neg: Coil Objects=M4PhCC1neg Conductor_number=$cond Winding=M4PhC PolarityType=Negative
  M4PhCC2neg: Coil Objects=M4PhCC2neg Conductor_number=$cond Winding=M4PhC PolarityType=Negative
  M4PhCC2pos: Coil Objects=M4PhCC2pos Conductor_number=$cond Winding=M4PhC PolarityType=Positive
  M1PhA: Winding Group Type=External IsSolid=false Current=0mA ParallelBranchesNum=1
  M2PhA: Winding Group Type=External IsSolid=false Current=0mA ParallelBranchesNum=1
  M3PhA: Winding Group Type=External IsSolid=false Current=0mA ParallelBranchesNum=1
  M4PhA: Winding Group Type=External IsSolid=false Current=0mA ParallelBranchesNum=1
  M1PhB: Winding Group Type=External IsSolid=false Current=0mA ParallelBranchesNum=1
  M1PhC: Winding Group Type=External IsSolid=false Current=0mA ParallelBranchesNum=1
  M2PhB: Winding Group Type=External IsSolid=false Current=0mA ParallelBranchesNum=1
  M2PhC: Winding Group Type=External IsSolid=false Current=0mA ParallelBranchesNum=1
  M3PhB: Winding Group Type=External IsSolid=false Current=0mA ParallelBranchesNum=1
  M3PhC: Winding Group Type=External IsSolid=false Current=0mA ParallelBranchesNum=1
  M4PhB: Winding Group Type=External IsSolid=false Current=0mA ParallelBranchesNum=1
  M4PhC: Winding Group Type=External IsSolid=false Current=0mA ParallelBranchesNum=1
  external circuit: "* Design: ex_cur\"
mesh:
  SurfApprox1: SurfApproxBased Objects=[M1PhAC2pos, M1PhBC1pos, M1PhBC2neg, M1PhCC1neg, M1PhCC2pos, M2PhAC1pos, M1PhAC1pos, M1PhAC2neg, M1PhBC1neg, M1PhBC2pos, M1PhCC1pos, M1PhCC2neg, Split1, Split2, M2PhCC1pos, M3PhCC1neg, M4PhCC1pos, M2PhAC2neg, M3PhAC2pos, M4PhAC2neg, M2PhBC1neg, M3PhBC1pos, M4PhBC1neg, M2PhBC2pos, M3PhBC2neg, M4PhBC2pos, M2PhCC2neg, M3PhCC2pos, M4PhCC2neg, M3PhAC1neg, M4PhAC1pos, M1PhAC1neg, M2PhAC1neg, M3PhAC1pos, M4PhAC1neg, M2PhAC2pos, M3PhAC2neg, M4PhAC2pos, M2PhBC1pos, M3PhBC1neg, M4PhBC1pos, M2PhBC2neg, M3PhBC2pos, M4PhBC2neg, M2PhCC1neg, M3PhCC1pos, M4PhCC1neg, M2PhCC2pos, M3PhCC2neg, M4PhCC2pos, Stator, Shaft, Rotor, OuterRegion, Band, InnerRegion] CurvedSurfaceApproxChoice=UseSlider SliderMeshSettings=7
  initial mesh: MeshMethod=AnsoftClassic
setups:
  Setup1: Transient NonlinearSolverResidual=0.0001 StopTime=36ms TimeStep=5e-005s SweepSetupType=LinearStep StartValue=0.05s StopValue=0.07s StepSize=0.0005s InitialTimeStep=0.002s MinTimeStep=0.001s MaxTimeStep=0.003s TimeStepErrTolerance=0.0001
field plots:
  Mag_B1, B_Vector1: B over M1PhAC2pos, M1PhBC1pos, M1PhBC2neg, M1PhCC1neg, M1PhCC2pos, M2PhAC1pos, M1PhAC1pos, M1PhAC2neg, M1PhBC1neg, M1PhBC2pos, M1PhCC1pos, M1PhCC2neg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 on Setup1 : Transient at Time=-1
  Mesh1: MeshPlots over M1PhAC2pos, M1PhBC1pos, M1PhBC2neg, M1PhCC1neg, M1PhCC2pos, M2PhAC1pos, M1PhAC1pos, M1PhAC2neg, M1PhBC1neg, M1PhBC2pos, M1PhCC1pos, M1PhCC2neg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 on Setup1 : Transient at Time=-1
reports:
  Torque: Moving1.Torque vs Time on Setup1 : Transient [embrace=all]; markers m1 at 76920000ns, m2 at 77380000ns, m3 at 48.1ms, m4 at 7.2ms
  V_ind: InducedVoltage(M1PhA), InducedVoltage(M1PhB), InducedVoltage(M1PhC) vs Time on Setup1 : Transient [embrace=all]; markers m1 at 62.13ms
  Current: BranchCurrent(Vm1a), BranchCurrent(Vm1b), BranchCurrent(Vm1c) vs Time on Setup1 : Transient
  One Module: InducedVoltage(M1PhA), NodeVoltage(Im1a), Current(M1PhA) vs Time on Setup1 : Transient; markers m1 at 32700000ns, m2 at 12.7ms, m3 at 12.8ms
  V_in: NodeVoltage(Im1a), NodeVoltage(Im1b), NodeVoltage(Im1c) vs Time on Setup1 : Transient
  Flux: FluxLinkage(M1PhA), FluxLinkage(M1PhB), FluxLinkage(M1PhC) vs Time on Setup1 : Transient [embrace=all]
  Power: 4*(BranchCurrent(Vm1a)*NodeVoltage(Im1a)+BranchCurrent(Vm1b)*NodeVoltage(Im1b)+BranchCurrent(Vm1c)*NodeVoltage(Im1c)), Moving1.Torque*Moving1.Speed vs Time on Setup1 : Transient

design ex_vol (Maxwell Circuit)
components:
  Winding_663 = Winding(Name=M1PhA)
  Winding_664 = Winding(Name=M1PhC)
  Winding_665 = Winding(Name=M1PhB)
  Ind_666 = Ind(L=$ind)
  Ind_667 = Ind(L=$ind)
  Ind_668 = Ind(L=$ind)
  Res_669 = Res(R=$res)
  Res_670 = Res(R=$res)
  Res_671 = Res(R=$res)
  VSin_672 = VSin(Va=$vpeak VFreq=100 Phase=$ang)
  Res_673 = Res(R=$res)
  Res_674 = Res(R=$res)
  Res_675 = Res(R=$res)
  Ind_676 = Ind(L=$ind)
  Ind_677 = Ind(L=$ind)
  Ind_678 = Ind(L=$ind)
  Winding_679 = Winding(Name=M2PhB)
  Winding_680 = Winding(Name=M2PhC)
  Winding_681 = Winding(Name=M2PhA)
  Res_682 = Res(R=$res)
  Res_683 = Res(R=$res)
  Res_684 = Res(R=$res)
  Ind_685 = Ind(L=$ind)
  Ind_686 = Ind(L=$ind)
  Ind_687 = Ind(L=$ind)
  Winding_688 = Winding(Name=M4PhB)
  Winding_689 = Winding(Name=M4PhC)
  Winding_690 = Winding(Name=M4PhA)
  Res_691 = Res(R=$res)
  Res_692 = Res(R=$res)
  Res_693 = Res(R=$res)
  Ind_694 = Ind(L=$ind)
  Ind_695 = Ind(L=$ind)
  Ind_696 = Ind(L=$ind)
  Winding_697 = Winding(Name=M3PhB)
  Winding_698 = Winding(Name=M3PhC)
  Winding_699 = Winding(Name=M3PhA)
  VSin_700 = VSin(Va=$vpeak VFreq=100 Phase=$ang)
  VSin_701 = VSin(Va=$vpeak VFreq=100 Phase=$ang)
  VSin_702 = VSin(Va=$vpeak VFreq=100 Phase=$ang)
  VSin_703 = VSin(Va=$vpeak VFreq=100 Phase="240deg + $ang")
  VSin_704 = VSin(Va=$vpeak VFreq=100 Phase="120deg + $ang")
  VSin_705 = VSin(Va=$vpeak VFreq=100 Phase="120deg + $ang")
  VSin_706 = VSin(Va=$vpeak VFreq=100 Phase="120deg + $ang")
  VSin_707 = VSin(Va=$vpeak VFreq=100 Phase="120deg + $ang")
  VSin_708 = VSin(Va=$vpeak VFreq=100 Phase="240deg + $ang")
  VSin_709 = VSin(Va=$vpeak VFreq=100 Phase="240deg + $ang")
  VSin_710 = VSin(Va=$vpeak VFreq=100 Phase="240deg + $ang")
  VoltmeterG_711 = VoltmeterG(Name=m1a)
  VoltmeterG_712 = VoltmeterG(Name=m1c)
  VoltmeterG_713 = VoltmeterG(Name=m1b)
  Ammeter_714 = Ammeter(Name=m1b)
  Ammeter_715 = Ammeter(Name=m1c)
  Ammeter_716 = Ammeter(Name=m1a)
nets:
  0: VSin_672.1, VSin_704.1, VSin_705.1, VSin_706.1, VSin_707.1, VSin_708.1, VSin_702.1, VSin_709.1, VSin_703.1, VSin_701.1, VSin_700.1, VSin_710.1
  net_1: Ind_666.0, Winding_663.1
  net_15: Winding_679.0, VSin_704.0
  net_16: Winding_680.0, VSin_703.0
  net_17: Winding_681.0, VSin_702.0
  net_18: Ind_676.0, Winding_679.1
  net_19: Res_673.0, Ind_676.1
  net_2: Ind_666.1, Res_669.0
  net_20: Ind_677.1, Res_674.0
  net_21: Ind_677.0, Winding_680.1
  net_22: Res_675.0, Ind_678.1
  net_23: Ind_678.0, Winding_681.1
  net_26: VSin_705.0, Winding_688.0
  net_27: VSin_708.0, Winding_689.0
  net_28: Winding_690.0, VSin_701.0
  net_29: Ind_685.0, Winding_688.1
  net_3: Winding_664.1, Ind_667.0
  net_30: Res_682.0, Ind_685.1
  net_31: Res_683.0, Ind_686.1
  net_32: Ind_686.0, Winding_689.1
  net_33: Ind_687.1, Res_684.0
  net_34: Ind_687.0, Winding_690.1
  net_37: Winding_697.0, VSin_706.0
  net_38: VSin_709.0, Winding_698.0
  net_39: Winding_699.0, VSin_700.0
  net_4: Res_670.0, Ind_667.1
  net_40: Winding_697.1, Ind_694.0
  net_41: Res_691.0, Ind_694.1
  net_42: Res_692.0, Ind_695.1
  net_43: Winding_698.1, Ind_695.0
  net_44: Res_693.0, Ind_696.1
  net_45: Winding_699.1, Ind_696.0
  net_46: Res_693.1, Res_691.1, Res_692.1
  net_47: Res_682.1, Res_683.1, Res_684.1
  net_48: Res_675.1, Res_673.1, Res_674.1
  net_49: Res_671.1, Res_670.1, Res_669.1
  net_5: Res_671.0, Ind_668.1
  net_50: VSin_707.0, Ammeter_714.0, VoltmeterG_713.0
  net_51: VSin_672.0, Ammeter_716.0, VoltmeterG_711.0
  net_52: Winding_664.0, Ammeter_715.1
  net_6: Winding_665.1, Ind_668.0
  net_7: Winding_663.0, Ammeter_716.1
  net_8: VSin_710.0, VoltmeterG_712.0, Ammeter_715.0
  net_9: Winding_665.0, Ammeter_714.1

design ex_cur (Maxwell Circuit)
components:
  Voltmeter_779 = Voltmeter()
  ISin_780 = ISin(Ia=0A IFreq=100 Phase="-240deg + $ang")
  ISin_781 = ISin(Ia=0A IFreq=100 Phase="-240deg + $ang")
  ISin_782 = ISin(Ia=0A IFreq=100 Phase="-240deg + $ang")
  ISin_783 = ISin(Ia=0A IFreq=100 Phase="-120deg + $ang")
  ISin_784 = ISin(Ia=0A IFreq=100 Phase="-120deg + $ang")
  ISin_785 = ISin(Ia=0A IFreq=100 Phase="-120deg + $ang")
  ISin_786 = ISin(Ia=0A IFreq=100 Phase=$ang)
  ISin_787 = ISin(Ia=0A IFreq=100 Phase=$ang)
  ISin_788 = ISin(Ia=0A IFreq=100 Phase=$ang)
  ISin_789 = ISin(Ia=0A IFreq=100 Phase="-240deg + $ang")
  ISin_790 = ISin(Ia=0A IFreq=100 Phase="-120deg + $ang")
  ISin_791 = ISin(Ia=0A IFreq=100 Phase=$ang)
  Voltmeter_792 = Voltmeter()
  Voltmeter_793 = Voltmeter(Name=vapp)
  Ammeter_794 = Ammeter(Name=m1a)
  Ammeter_795 = Ammeter(Name=m1c)
  Ammeter_796 = Ammeter(Name=m1b)
  VoltmeterG_797 = VoltmeterG(Name=m1b)
  VoltmeterG_798 = VoltmeterG(Name=m1c)
  VoltmeterG_799 = VoltmeterG(Name=m1a)
  Winding_800 = Winding(Name=M3PhA)
  Winding_801 = Winding(Name=M3PhC)
  Winding_802 = Winding(Name=M3PhB)
  Ind_803 = Ind(L=$ind)
  Ind_804 = Ind(L=$ind)
  Ind_805 = Ind(L=$ind)
  Res_806 = Res(R=$res)
  Res_807 = Res(R=$res)
  Res_808 = Res(R=$res)
  Winding_809 = Winding(Name=M4PhA)
  Winding_810 = Winding(Name=M4PhC)
  Winding_811 = Winding(Name=M4PhB)
  Ind_812 = Ind(L=$ind)
  Ind_813 = Ind(L=$ind)
  Ind_814 = Ind(L=$ind)
  Res_815 = Res(R=$res)
  Res_816 = Res(R=$res)
  Res_817 = Res(R=$res)
  Winding_818 = Winding(Name=M2PhA)
  Winding_819 = Winding(Name=M2PhC)
  Winding_820 = Winding(Name=M2PhB)
  Ind_821 = Ind(L=$ind)
  Ind_822 = Ind(L=$ind)
  Ind_823 = Ind(L=$ind)
  Res_824 = Res(R=$res)
  Res_825 = Res(R=$res)
  Res_826 = Res(R=$res)
  Res_827 = Res(R=$res)
  Res_828 = Res(R=$res)
  Res_829 = Res(R=$res)
  Ind_830 = Ind(L=$ind)
  Ind_831 = Ind(L=$ind)
  Ind_832 = Ind(L=$ind)
  Winding_833 = Winding(Name=M1PhB)
  Winding_834 = Winding(Name=M1PhC)
  Winding_835 = Winding(Name=M1PhA)
nets:
  0: ISin_786.0, ISin_787.0, ISin_780.0, ISin_781.0, ISin_782.0, ISin_790.0, ISin_788.0, ISin_791.0, Voltmeter_793.1, Voltmeter_779.1, Voltmeter_792.1, ISin_783.0, ISin_785.0, ISin_784.0, ISin_789.0, Res_806.1, Res_808.1, Res_824.1, Res_826.1, Res_827.1, Res_828.1, Res_825.1, Res_815.1, Res_829.1, Res_807.1, Res_817.1, Res_816.1
  net_100: Ind_831.0, Winding_834.1
  net_101: Res_829.0, Ind_832.1
  net_102: Ind_832.0, Winding_835.1
  net_55: Ammeter_796.1, Voltmeter_779.0, Winding_833.0
  net_56: ISin_782.1, Winding_820.0
  net_57: ISin_784.1, Winding_810.0
  net_59: ISin_780.1, Winding_811.0
  net_60: ISin_786.1, Winding_809.0
  net_61: ISin_781.1, Winding_802.0
  net_62: Winding_801.0, ISin_785.1
  net_63: Winding_800.0, ISin_788.1
  net_64: Ammeter_795.1, Voltmeter_792.0, Winding_834.0
  net_65: ISin_791.1, Ammeter_794.0, VoltmeterG_799.0
  net_66: VoltmeterG_797.0, Ammeter_796.0, ISin_789.1
  net_67: Winding_800.1, Ind_803.0
  net_68: Ind_803.1, Res_806.0
  net_69: Winding_801.1, Ind_804.0
  net_70: Res_807.0, Ind_804.1
  net_71: Res_808.0, Ind_805.1
  net_72: Winding_802.1, Ind_805.0
  net_76: Winding_809.1, Ind_812.0
  net_77: Res_815.0, Ind_812.1
  net_78: Ind_813.0, Winding_810.1
  net_79: Ind_813.1, Res_816.0
  net_80: Ind_814.1, Res_817.0
  net_81: Ind_814.0, Winding_811.1
  net_84: Winding_818.1, Ind_821.0
  net_85: Res_824.0, Ind_821.1
  net_86: Ind_822.0, Winding_819.1
  net_87: Ind_822.1, Res_825.0
  net_88: Res_826.0, Ind_823.1
  net_89: Winding_820.1, Ind_823.0
  net_90: ISin_787.1, Winding_818.0
  net_91: ISin_783.1, Winding_819.0
  net_95: Ammeter_795.0, VoltmeterG_798.0, ISin_790.1
  net_96: Ammeter_794.1, Voltmeter_793.0, Winding_835.0
  net_97: Ind_830.0, Winding_833.1
  net_98: Res_827.0, Ind_830.1
  net_99: Res_828.0, Ind_831.1
